addrmap apb_interconnect #(
    longint unsigned N_MST_PORTS = 1,
    longint unsigned DATA_WIDTH = 32,
    longint unsigned ADDR_WIDTH = 32,

    longint unsigned MEM_MAP[]

    ){

    apb_intf #(
        .INTF(intf_t'{name:"apb_intf", DATA_WIDTH:DATA_WIDTH, ADDR_WIDTH:ADDR_WIDTH, prefix:"s_", modport:Modport::slave }),
        .N(1)
        )  s_;

    apb_intf #(
        .INTF(intf_t'{name:"apb_intf", DATA_WIDTH:DATA_WIDTH, ADDR_WIDTH:ADDR_WIDTH, prefix:"m_", modport:Modport::master }),
        .N(N_MST_PORTS)
        )  m_;

    reg {name = "dummy"; field {sw = r; hw = w;} dummy[1] = 0;} dummy;

};

