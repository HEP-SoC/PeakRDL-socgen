addrmap nmi_bus #(
    longint unsigned ADDR_WIDTH = 32,
    longint unsigned DATA_WIDTH = 32

    
    ){
    bus;
    interconnect_name = "nmi_interconnect";

    signal  { 
        signalwidth=1; 
        activehigh = true;
        mosi;
        ss;

        desc = "Indicates that a valid transaction was put on the bus. Valid should stay valid until the ready signal is received.";
    } nmi_valid;

    signal { 
        signalwidth=1; 
        activehigh = true;
        miso;

        desc = "Ready is driven by the slave, and acknowledges the handshake between master and slave.";
    } nmi_ready;

    signal  { 
        signalwidth=1; 
        activehigh = true;
        mosi;

        desc = "This signal is asserted on CPU instruction fetch to indicate instruction memory read, (OPTIONAL).";
    } nmi_instr;

    signal { 
        signalwidth=ADDR_WIDTH; 
        mosi;

        desc = "Address. This is the APB address bus. It can be up to 32 bits wide and is driven by the peripheral bus bridge unit.";
    } nmi_addr;

    signal { 
        signalwidth=DATA_WIDTH; 
        mosi;

        desc = "Write data, data to be written to the slave from master.";
    } nmi_wdata;

    signal { 
        signalwidth=DATA_WIDTH; 
        miso;

        desc = "Read data, data read from the slave received by master.";
    } nmi_rdata;

    signal { 
        signalwidth=DATA_WIDTH/8; 
        mosi;

        desc = "Write data, data to be written to the slave from master.";
    } nmi_wstrb;

 reg {
     name = "sw_done";
     desc = "";

     field {
         name = "Software execution done register";
         sw = w; hw = r;} sw_done[32] = 0;
     } sw_done;

};
