signal lowrisc_if_req #(longint unsigned W=1){ signalwidth=W; mosi; ss; };
signal lowrisc_if_addr #(longint unsigned W=32){ signalwidth=W; mosi; ss; };
signal lowrisc_if_we #(longint unsigned W=1){ signalwidth=W; mosi; ss; };
signal lowrisc_if_be #(longint unsigned W=4){ signalwidth=W; mosi; ss; };
signal lowrisc_if_wdata #(longint unsigned W=32){ signalwidth=W; mosi; ss; };
signal lowrisc_if_wdata_intg #(longint unsigned W=7){ signalwidth=W; mosi; ss; };
signal lowrisc_if_gnt #(longint unsigned W=1){ signalwidth=W; miso; ss; };
signal lowrisc_if_rvalid #(longint unsigned W=1){ signalwidth=W; miso; ss; };
signal lowrisc_if_err #(longint unsigned W=1){ signalwidth=W; miso; ss; };
signal lowrisc_if_rdata #(longint unsigned W=32){ signalwidth=W; miso; ss; };
signal lowrisc_if_rdata_intg #(longint unsigned W=7){ signalwidth=W; miso; ss; };


addrmap lowrisc_if_intf #(
    intf_t INTF = intf_t'{name:"lowrisc_if_intf", ADDR_WIDTH:32, DATA_WIDTH:32, prefix:"", modport:Modport::slave},
    longint unsigned N=1
    ){
    intf;
    intf_inst = INTF;
    n_array = N;

    lowrisc_if_req        #(.W(N*1))                  req;
    lowrisc_if_addr       #(.W(N*INTF.ADDR_WIDTH))    addr;
    lowrisc_if_we         #(.W(N*1))                  we;
    lowrisc_if_be         #(.W(N*4))                  be;
    lowrisc_if_wdata      #(.W(N*32))                 wdata;
    lowrisc_if_wdata_intg #(.W(N*7))                  wdata_intg;
    lowrisc_if_gnt        #(.W(N))                    gnt;
    lowrisc_if_rvalid     #(.W(N))                    rvalid;
    lowrisc_if_err        #(.W(N))                    err;
    lowrisc_if_rdata      #(.W(N*32))                 rdata;
    lowrisc_if_rdata_intg #(.W(N*7))                  rdata_intg;

    clk ACLK;
    rstn ARESETn;


 reg {name = "dummy"; field {sw = r; hw = w;} dummy[1] = 0;} dummy;

};
