signal pulpif_req #(longint unsigned W=1){ signalwidth=W; mosi; ss; };
signal pulpif_addr #(longint unsigned W=32){ signalwidth=W; mosi; ss; };
signal pulpif_we #(longint unsigned W=1){ signalwidth=W; mosi; ss; };
signal pulpif_be #(longint unsigned W=4){ signalwidth=W; mosi; ss; };
signal pulpif_wdata #(longint unsigned W=32){ signalwidth=W; mosi; ss; };
signal pulpif_wdata_intg #(longint unsigned W=7){ signalwidth=W; mosi; ss; };
signal pulpif_gnt #(longint unsigned W=1){ signalwidth=W; miso; ss; };
signal pulpif_rvalid #(longint unsigned W=1){ signalwidth=W; miso; ss; };
signal pulpif_err #(longint unsigned W=1){ signalwidth=W; miso; ss; };
signal pulpif_rdata #(longint unsigned W=32){ signalwidth=W; miso; ss; };
signal pulpif_rdata_intg #(longint unsigned W=7){ signalwidth=W; miso; ss; };


addrmap pulpif_intf #(
    intf_t INTF = intf_t'{name:"pulpif_intf", ADDR_WIDTH:32, DATA_WIDTH:32, prefix:"", modport:Modport::slave},
    longint unsigned N=1
    ){
    intf;
    intf_inst = INTF;
    n_array = N;

    pulpif_req        #(.W(N*1))                  req;
    pulpif_addr       #(.W(N*INTF.ADDR_WIDTH))    addr;
    pulpif_we         #(.W(N*1))                  we;
    pulpif_be         #(.W(N*4))                  be;
    pulpif_wdata      #(.W(N*32))                 wdata;
    pulpif_wdata_intg #(.W(N*7))                  wdata_intg;
    pulpif_gnt        #(.W(N))                    gnt;
    pulpif_rvalid     #(.W(N))                    rvalid;
    pulpif_err        #(.W(N))                    err;
    pulpif_rdata      #(.W(N*32))                 rdata;
    pulpif_rdata_intg #(.W(N*7))                  rdata_intg;

 reg {name = "dummy"; field {sw = r; hw = w;} dummy[1] = 0;} dummy;

};


