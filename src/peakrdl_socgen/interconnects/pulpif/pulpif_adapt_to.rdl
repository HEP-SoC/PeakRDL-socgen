addrmap pulpif2axi #(
    longint unsigned DATA_WIDTH = 32,
    longint unsigned ADDR_WIDTH = 32

    ){
    adapter;

    pulpif_intf #(
        .INTF(intf_cap'{name:"pulpif_intf", DATA_WIDTH:DATA_WIDTH, ADDR_WIDTH:ADDR_WIDTH, prefix:"mem_", modport:Modport::slave, cap:false }),
        .N(1)
        )  slave;

    axi_intf #(
        .INTF(intf_cap'{name:"axi_intf", DATA_WIDTH:DATA_WIDTH, ADDR_WIDTH:ADDR_WIDTH, prefix:"M_AXI_", modport:Modport::master, cap:true }),
        .N(1)
        )  master;

    reg {name = "dummy"; field {sw = r; hw = w;} dummy[1] = 0;} dummy;

    clk clk;
    rstn rstn;

};

addrmap pulpif2axi_lite #(
    longint unsigned DATA_WIDTH = 32,
    longint unsigned ADDR_WIDTH = 32

    ){
    adapter;

    pulpif_intf #(
        .INTF(intf_cap'{name:"pulpif_intf", DATA_WIDTH:DATA_WIDTH, ADDR_WIDTH:ADDR_WIDTH, prefix:"mem_", modport:Modport::slave, cap:false }),
        .N(1)
        )  slave;

    axi_lite_intf #(
        .INTF(intf_cap'{name:"axi_intf", DATA_WIDTH:DATA_WIDTH, ADDR_WIDTH:ADDR_WIDTH, prefix:"M_AXI_", modport:Modport::master, cap:true }),
        .N(1)
        )  master;

    reg {name = "dummy"; field {sw = r; hw = w;} dummy[1] = 0;} dummy;

    clk clk;
    rstn rstn;

};
