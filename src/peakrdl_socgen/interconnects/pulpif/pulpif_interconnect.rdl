addrmap pulpif_interconnect #(
    longint unsigned N_SLV_PORTS = 1,
    longint unsigned N_MST_PORTS = 1,
    longint unsigned DATA_WIDTH = 32,
    longint unsigned ADDR_WIDTH = 32,

    longint unsigned SLAVE_ADDR[],
    longint unsigned SLAVE_MASK[]



    ){

    pulpif_intf #(
        .INTF(intf_t'{name:"pulpif_intf", DATA_WIDTH:DATA_WIDTH, ADDR_WIDTH:ADDR_WIDTH, prefix:"host_", modport:Modport::slave }),
        .N(N_SLV_PORTS)
        )  host_;

    pulpif_intf #(
        .INTF(intf_t'{name:"pulpif_intf", DATA_WIDTH:DATA_WIDTH, ADDR_WIDTH:ADDR_WIDTH, prefix:"device_", modport:Modport::master }),
        .N(N_MST_PORTS)
        )  device_;


    clk clk_i;
    rstn rst_ni;

    reg {name = "dummy"; field {sw = r; hw = w;} dummy[1] = 0;} dummy;
};

