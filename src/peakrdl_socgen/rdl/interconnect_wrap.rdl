addrmap interconnect_wrap #(
    intf_cap INTF[] = '{intf_cap'{name:"dummy", ADDR_WIDTH:0, DATA_WIDTH:0, prefix:"dummy", modport:Modport::slave, cap:false}}
    ){

    intfs = INTF;


    clk intcw_clk;
    rstn intcw_rstn;

    reg {name = "dummy"; field {sw = r; hw = w;} dummy[1] = 0;} dummy;
};


