// SPDX-License-Identifier: GPL-3.0-only
// Copyright (c) 2025 CERN
//
// Please retain this header in all redistributions and modifications of the code.

addrmap interconnect_wrap #(
    base_intf INTF[] = '{}
    ){

    ifports = INTF;


    clk intcw_clk;
    rstn intcw_rstn;

    reg {name = "dummy"; field {sw = r; hw = w;} dummy[1] = 0;} dummy;
};


