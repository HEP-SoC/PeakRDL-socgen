addrmap interconnect_wrap #(
    base_intf INTF[] = '{}
    ){

    ifports = INTF;


    clk intcw_clk;
    rstn intcw_rstn;

    reg {name = "dummy"; field {sw = r; hw = w;} dummy[1] = 0;} dummy;
};


